# Ansys Electronics Desktop project, version 2021.2
materials:
  vacuum: permittivity=1

design HFSSDesign1 (HFSS, DrivenModal, model units mm)
geometry:
  Box1 = box(corner=(0mm, 0mm, 0mm), size=(0.9in, 0.9in, 0.4in))
  Box1_ObjectFromFace1 [vacuum] = object_from(Box1_ObjectFromFace1.face(5 of 6))
  Box1_ObjectFromFace1.sweep_along_vector((0mm, 10.5mm, 0mm), draft=20deg Extended)
  Box1_ObjectFromFace1.uncover_faces(FacesToUncover=Box1_ObjectFromFace1.face(#101))
  Box1_ObjectFromFace1.uncover_faces(FacesToUncover=Box1_ObjectFromFace1.face(at (11.43, 22.86, 5.08)))
  Box1.uncover_faces(FacesToUncover=Box1_ObjectFromFace1.face(5 of 6))
  Box1_ObjectFromFace1.unite(Box1)
  Box2 [vacuum] = box(corner=(-100mm, 0mm, -100mm), size=(200mm, 200mm, 200mm))
boundaries and excitations:
  PerfE1: Perfect E Faces=Box1_ObjectFromFace1.face(#97)
  PerfE2: Perfect E Faces=Box1_ObjectFromFace1.face(#100)
  PerfE3: Perfect E Faces=Box1_ObjectFromFace1.face(#99)
  PerfE4: Perfect E Faces=Box1_ObjectFromFace1.face(#98)
  PerfE5: Perfect E Faces=Box1_ObjectFromFace1.face(1 of 6)
  PerfE6: Perfect E Faces=Box1_ObjectFromFace1.face(4 of 6)
  PerfE7: Perfect E Faces=Box1_ObjectFromFace1.face(6 of 6)
  PerfE8: Perfect E Faces=Box1_ObjectFromFace1.face(2 of 6)
  Rad1: Radiation Objects=Box2
  1: Wave Port Faces=Box1_ObjectFromFace1.face(3 of 6) NumModes=1 Modes{Mode1{IntLine{middle of Box1_ObjectFromFace1.edge(6 of 12) -> middle of Box1_ObjectFromFace1.edge(4 of 12)} CharImp=Zpi}}
setups:
  Setup1: HfssDriven Frequency=11GHz MaxDeltaS=0.1 MaximumPasses=10 MinimumPasses=1 MinimumConvergedPasses=1 PercentRefinement=30 BasisOrder=1 PortAccuracy=2
    sweep Sweep: 5.5GHz to 16.5GHz, 401 points; Type=Fast SaveFields
source amplitudes:
  1:1: 1W 0deg
radiation setups:
  Infinite Sphere1: Infinite Sphere Theta=0deg..180deg step 2deg Phi=0deg..360deg step 2deg
